*** nmos analysis ***

.param scale_n = '10u/7.539e-5'
.param scale_p = '10u/6.942e-6'

.lib "/usr/local/share/pdk/share/pdk/sky130A/libs.tech/ngspice/sky130.lib.spice" tt

Vdd Vdd 0 DC 1.8
Vin_p Vin_p 0 DC 1 AC 0.5
Vin_n Vin_n 0 DC 1 AC -0.5

*** LOAD ***
R2 Vdd N2 54k
R1 N2 Nload 26k
XnMirror1 Nload N2 0 0 MY_NFET W_val=5 L_val=0.50

*** Load 2 ***
Iload2 0 N3 DC 75u
XnMirror2 N3 N3 0 0 MY_NFET W_val=5 L_val=0.50

Xota Vin_p Vin_n Vout1 Vdd N2 OTA
XCS Vout1 Vout Vdd N3 CSstage

.subckt OTA Vin_p Vin_n Vout Vdd Vload
    Xp1 Vdd N1 N1 Vdd MY_PFET W_val=5*scale_p
    Xp2 Vdd N1 Vout Vdd My_PFET W_val=5*scale_p

    Xn1 N1 Vin_p AC_gnd AC_gnd MY_NFET W_val=5*scale_n
    Xn2 Vout Vin_n AC_gnd AC_gnd MY_NFET W_val=5*scale_n

    Cc Vout 0 2p

    *** LOAD ***
    Xnload AC_gnd Vload 0 0 MY_NFET W_val=5 L_val=0.50
.ends OTA

.subckt CSstage Vin Vout Vdd Vload
    Xp1 Vdd Vin Vout Vdd MY_PFET W_val=5*6
    Xp2 Vdd Vin Vout Vdd MY_PFET W_val=5*6

    ***Feedthrough Branch***
    Rz Vin N1 9k
    Cz N1 Vout 2p

    *** Cload ***
    Cload Vout 0 5p

    *** LOAD ***
    Xnload Vout Vload 0 0 MY_NFET W_val=5 L_val=0.50
.ends CSstage

*** devices ***
.subckt MY_PFET Vs Vg Vd Vb W_val=5 L_val=0.30
    XMP Vd Vg Vs Vb sky130_fd_pr__pfet_01v8 W='W_val' L='L_val'
+ ad=  {int((nf+1)/2)*w/nf*0.29}
+ as=  {int((nf+2)/2)*w/nf*0.29}
+ pd=  {2*int((nf+1)/2)*(w/nf+0.29)}
+ ps=  {2*int((nf+2)/2)*(w/nf+0.29)}
+ nrd= {0.29/w}
+ nrs= {0.29/w}
+ sa = 0 sb = 0 sd = 0
.ends MY_PFET

.subckt MY_NFET Vd Vg Vs Vb W_val=5 L_val=0.15
    XMN Vd Vg Vs Vb sky130_fd_pr__nfet_01v8 W='W_val' L='L_val'
+ ad=  {int((nf+1)/2)*w/nf*0.29}
+ as=  {int((nf+2)/2)*w/nf*0.29}
+ pd=  {2*int((nf+1)/2)*(w/nf+0.29)}
+ ps=  {2*int((nf+2)/2)*(w/nf+0.29)}
+ nrd= {0.29/w}
+ nrs= {0.29/w}
+ sa = 0 sb = 0 sd = 0
.ends MY_NFET

.control
    ac dec 100 1 10G
    options units=degrees
    meas ac gbw_freq WHEN vdb(vout)=0 cross=1
    meas ac phase_at_gbw FIND vp(vout) WHEN vdb(vout)=0 cross=1
    let pm = 180 + phase_at_gbw
    print gbw_freq
    print phase_at_gbw
    print pm
    plot db(vout) ph(vout)
.endc

.end
