*** nmos analysis ***

.param scale_n = '10u/7.539e-5'
.param scale_p = '10u/6.942e-6'

.lib "$PDK_ROOT/sky130A/libs.tech/ngspice/sky130.lib.spice" tt

Vdd Vdd 0 DC 1.8
Vin_p Vin_p 0 DC 1 AC 0.5
Vin_n Vin_n 0 DC 1 AC -0.5

Xp1 Vdd N1 N1 Vdd MY_PFET W_val=5*scale_p
Xp2 Vdd N1 Vout Vdd My_PFET W_val=5*scale_p

Xn1 N1 Vin_p AC_gnd AC_gnd MY_NFET W_val=5*scale_n
Xn2 Vout Vin_n AC_gnd AC_gnd MY_NFET W_val=5*scale_n

Cc Vout 0 2p

*** LOAD ***
R2 Vdd N2 54k
R1 N2 Nload 26k
XnMirror1 Nload N2 0 0 MY_NFET W_val=5 L_val=0.50
Xnload AC_gnd N2 0 0 MY_NFET W_val=5 L_val=0.50

*** devices ***
.subckt MY_PFET Vs Vg Vd Vb W_val=5 L_val=0.30
    XMP Vd Vg Vs Vb sky130_fd_pr__pfet_01v8 W='W_val' L='L_val'
+ ad=  {int((nf+1)/2)*w/nf*0.29}
+ as=  {int((nf+2)/2)*w/nf*0.29}
+ pd=  {2*int((nf+1)/2)*(w/nf+0.29)}
+ ps=  {2*int((nf+2)/2)*(w/nf+0.29)}
+ nrd= {0.29/w}
+ nrs= {0.29/w}
+ sa = 0 sb = 0 sd = 0
.ends MY_PFET

.subckt MY_NFET Vd Vg Vs Vb W_val=5 L_val=0.15
    XMN Vd Vg Vs Vb sky130_fd_pr__nfet_01v8 W='W_val' L='L_val'
+ ad=  {int((nf+1)/2)*w/nf*0.29}
+ as=  {int((nf+2)/2)*w/nf*0.29}
+ pd=  {2*int((nf+1)/2)*(w/nf+0.29)}
+ ps=  {2*int((nf+2)/2)*(w/nf+0.29)}
+ nrd= {0.29/w}
+ nrs= {0.29/w}
+ sa = 0 sb = 0 sd = 0
.ends MY_NFET

.control
    op
    print n1 vout vdd#branch
.endc

.end
